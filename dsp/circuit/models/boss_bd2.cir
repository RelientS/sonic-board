* Boss BD-2 Blues Driver
*@name Boss BD-2 Blues Driver
*@input Vin
*@output out 1
*@oversample 2
*@pot level RlevA RlevB 100k log
*@pot tone RtoneA RtoneB 10k lin
*@pot gain1 RgainA - 250k log
*@pot gain2 RgainB - 250k log
*@control Level level default=0.5
*@control Tone tone default=0.5
*@control Gain gain1 gain2 default=0.5
*
* Source: Boss factory schematic "BD-2 MT BOARD ASSY 70567645 (PCB 00786489)"
* (schematicheaven.net/effects/boss_bd2_bluesdriver.pdf). Component names
* below are the Boss reference designators. Cross-checked against the
* gaussmarkov/stobiepole "Blues Driver Clone" redraw (2007) and the Aion FX
* Sapphire (stock BD-2) build document v1.0.1 (2024). Disagreement: the
* gaussmarkov redraw has C17 = 5.6n; Boss and Aion both give 6.8n (used here).
*
* Effect-on path only. The JFET bypass switches Q6/Q4 (2SK118Y, on) are
* modelled as their on-resistance; the bypass-path buffer Q5, the flip-flop
* (Q15/Q16) and the LED are omitted.
*
* Power: the 9 V input feeds a capacitance multiplier (Q2 2SC2458 + R6 2.2k +
* C4 47u) that gives the "+8V" rail; IC1A buffers R5/R4 (10k/10k) into the
* "+4V" bias VR. Both are replaced by ideal sources at the values the full
* supply settles to in ngspice (9 V - Q2 base drop 0.08 V - Vbe 0.76 V at ~10.7 mA total draw).
*
* Devices (no maker SPICE models exist for the Toshiba parts, so published
* same-maker same-grade stand-ins are used):
*   2SK184-GR JFET  -> LTspice 2SK117GR (same Toshiba die family, IDSS ~5.3 mA)
*   2SA1335-GR PNP  -> LTspice 2SA1015-GR (Toshiba, hFE 300)
*   2SC2458/2459-GR -> LTspice 2SC1815-GR (Toshiba, hFE 300)
*   1SS133 diode    -> 1N4148/1N914 model (IS 2.52n, N 1.752)
*   M5218AL op-amp  -> macro: GBW 7 MHz, SR 3 V/us, Aol 110 dB (datasheet typ.)
* JFET RD/RS (15 ohm) and all junction capacitances are dropped.

V8 v8 0 8.16
VR vr 0 4.08

* Guitar pickup source impedance (DI samples act as pickup EMF).
Vin src 0 0
Rpu src pu 6.5k
Lpu pu jack 2.3

* Q3 input buffer (source follower)
R18 jack n18 10k
C14 n18 g3 47n
R15 g3 vr 1meg
J3 v8 g3 s3 K184GR
R19 s3 0 10k

* Q6 effect switch (on) with its bias resistors
C15 s3 sw1a 10u
R17 sw1a vr 100k
RQ6 sw1a sw1b 150
R22 sw1b vr 100k

* Stage 1: discrete op-amp Q10/Q11 (JFET pair) + Q9 (PNP), gain 1+(R29+VR1A)/R31
C18 sw1b g10 0.1u
R23 g10 vr 220k
J10 d10 g10 st1 K184GR
J11 v8 g11 st1 K184GR
R30 st1 0 4.7k
R28 v8 d10 2.2k
Q9 o1 d10 v8 A1335GR
C21 d10 o1 47p
R32 o1 0 2.2k
C23 o1 g11 47p
R29 g11 ga1 22k
RgainA ga1 o1 250k
R31 g11 n31 1.5k
C22 n31 0 0.15u

* Clipping network: bass/treble split into 2+2 series 1SS133 to ground.
* Each series pair is one diode with N doubled (exact for identical diodes).
C26 o1 n26 220p
R37 n26 clip 330k
R38 o1 n38 100k
C34 n38 clip 0.1u
C35 n38 n51 0.047u
R50 clip n51 1meg
R51 n51 0 15k
D7 clip 0 D1SS133X2
D9 0 clip D1SS133X2

* Stage 2: discrete op-amp Q14/Q13 + Q12, gain 1+(R27+VR1B)/R34
C27 clip g14 2.2n
R35 g14 vr 1meg
J14 d14 g14 st2 K184GR
J13 v8 g13 st2 K184GR
R36 st2 0 4.7k
R33 v8 d14 2.2k
Q12 o2 d14 v8 A1335GR
C20 d14 o2 100p
R25 o2 0 2.2k
C25 o2 g13 100p
R27 g13 gb1 33k
RgainB gb1 o2 250k
R34 g13 n34 2.2k
C24 n34 0 1u

* Treble cut + Tone (VR2 10kB) and Level (VR3 100kA)
R26 o2 n19 5.6k
C17 o2 n19 6.8n
C19 n19 0 5.6n
C100 n19 t_hi 18n
RtoneA t_lo tone_w 5k
RtoneB tone_w t_hi 5k
C101 t_lo 0 18n
RlevA 0 lev_w 50k
RlevB lev_w tone_w 50k

* IC1B: non-inverting stage with bass boost (Q7 bootstrapped gyrator)
C10 lev_w p5 47n
R13 p5 vr 470k
D1 p5 n6 D1SS133
D3 n6 p5 D1SS133
XIC1B p5 n6 o7 M5218
R9 n6 o7 6.8k
C8 n6 o7 2.2n
C9 n6 m9 56n
C16 m9 b7 56n
R21 m9 e7 1.2k
R10 b7 vr 470k
Q7 v8 b7 e7 C2459GR
R20 e7 0 10k

* Q4 effect switch (on) and Q1 output buffer
C7 o7 sw2a 10u
R11 sw2a vr 100k
RQ4 sw2a sw2b 150
R8 sw2b vr 100k
C6 sw2b b1 10u
R7 b1 vr 100k
Q1 v8 b1 e1 C2459GR
R2 e1 0 10k
C1 e1 n1 10u
R3 n1 0 100k
R1 n1 out 1k
* Amplifier input load
Rload out 0 1meg

*@opamp M5218 gbw=7e6 slew=3e6 aol=3.16e5 vlo=1.0 vhi=7.25 rout=75
.model K184GR NJF(VTO=-0.42 BETA=30m LAMBDA=5m IS=10f)
.model A1335GR PNP(IS=295.1e-18 BF=300 BR=10.45 VAF=100 RC=15)
.model C2459GR NPN(IS=2.04f BF=300 BR=3.377 VAF=100 RC=1)
.model D1SS133 D(IS=2.52n N=1.752)
.model D1SS133X2 D(IS=2.52n N=3.504)
.end
